* rx ldo startup vin=5.0 bulk=2.2e-05
Vs src 0 5.0
Rc src a 0.1
Lc a in 100n
Cin in 0 2.4999999999999998e-05 ic=5.0
Rcin in 0 1meg
Ven en 0 PWL(0 0 100u 0 101u 1)
Rss en ss 1k
Css ss 0 2.666666666666667e-08 ic=0
B0 in o0 I = V(en) > 0.5 ? min(min(0.45, max(0, 200*(3.3*V(ss) - V(o0)))), max(0, (V(in) - V(o0))/0.5)) : 0
Co0 o0 0 4.7u ic=0
Rl0 o0 0 21.099744245524295
B1 in o1 I = V(en) > 0.5 ? min(min(0.45, max(0, 200*(3.3*V(ss) - V(o1)))), max(0, (V(in) - V(o1))/0.5)) : 0
Co1 o1 0 4.7u ic=0
Rl1 o1 0 18.13186813186813
B2 in o2 I = V(en) > 0.5 ? min(min(0.45, max(0, 200*(3.3*V(ss) - V(o2)))), max(0, (V(in) - V(o2))/0.5)) : 0
Co2 o2 0 4.7u ic=0
Rl2 o2 0 55.0
.options method=gear
.control
set wr_singlescale
set wr_vecnames
tran 0.2u 600u 0 0.2u uic
wrdata /home/user/sattelite-watch/sim/receiver_power/out/t.txt v(in) v(o0) v(o1) v(o2) vs#branch
.endc
.end
